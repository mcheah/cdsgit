/*
Initialize a Git Repository
CGPBinitForm(gs)
*/
procedure( CGPBinitForm(gs)

   importSkillVar(cdsGitAppName)
   ; printf("hello world")
   formTitle = sprintf(nil "%s Initialize a Repository" cdsGitAppName )
   formCB = "CGPBinitFormCB()"

   CGpathBrowseForm( gs ?formTitle formTitle ?formCB formCB ?formMode "directoryOnly" ?formLabel "Select a Path in which to Initialize a Git Repository")
)

procedure( CGPBinitFormCB()

   gsinit_path = StripCG(GSstr(cgpathbrowseform->sf_pathname->value))

   gs = GitShell( ?path gsinit_path ?skipCheck t)

   Init(gs)
   Check(gs)

   if( gs->valid then
      Info(gs sprintf(nil "Git Repository Initialized in %s" gsinit_path))
   else
      ErrorCG(gs sprintf(nil "Could not Initialize a Git Repository in %s\nCheck that you have permissions" gsinit_path))
   )

)
